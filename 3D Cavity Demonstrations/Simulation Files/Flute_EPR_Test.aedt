# Ansys Electronics Desktop project, version 2021.1
materials:
  vacuum: permittivity=1
  sapphire: permittivity=10

design Pan_pipe_w_qubit (HFSS, Eigenmode, model units mm)
variables:
  Stock_L = -2in
  Stock_W = 0.625in
  Stock_H = 2.25in
  Cav_width = 0.188in
  Q_hole_len = (((Stock_W) - (Cav_width)) / (2)) + ((Cav_width) / (2))
  Q_hole_dia = 0.125in
  Q_hole_loc_x = (Stock_L) / (2)
  Q_hole_loc_y = Stock_W
  Q_hole_loc_z = (Stock_H) / (2)
  Q_chip_y_offset = -0.05in
  Chip_W = 2.9mm
  Chip_L = 10mm
  Chip_H = 0.4mm
  Q_chip_loc_x = Q_hole_loc_x
  Q_chip_loc_y = (((Stock_W) / (2)) + ((Chip_L) / (2))) + (Q_chip_y_offset)
  Q_chip_loc_z = Q_hole_loc_z
  pad_y_offset = 0.5mm
  pad_l = 0.8mm
  pad_w = 350um
  pad_gap = 100um
  pad_x = (Q_chip_loc_x) - ((pad_w) / (2))
  pad_y = ((Q_chip_loc_y) + (pad_y_offset)) - ((Chip_L) / (2))
  pad_z = (Q_chip_loc_z) + ((Chip_H) / (2))
  jj_w = 50um
  pad_y_2 = ((pad_y) + (pad_l)) + (pad_gap)
  junc_y = (pad_y) + (pad_l)
  junc_x = (pad_x) + (((pad_w) - (jj_w)) / (2))
  Lj_1 = 11.2nH
geometry:
  Solid1 = imported_body(C:\_Lib\python\Automated-RF-Design\3D Cavity Demonstrations\Inventor Files\\single_mode_flute.stp)
  Box1 [vacuum] = box(corner=(0, 0, 0), size=(Stock_L, Stock_W, Stock_H))
  Box1.subtract(Solid1)
  Q_Hole = cylinder(axis=Y, base_centre=(Q_hole_loc_x, Q_hole_loc_y, Q_hole_loc_z), radius=(Q_hole_dia) / (2), height=-(Q_hole_len))
  Box1.unite(Q_Hole)
  Chip_sub = box(corner=((Q_chip_loc_x) - ((Chip_W) / (2)), (Q_chip_loc_y) - ((Chip_L) / (2)), (Q_chip_loc_z) - ((Chip_H) / (2))), size=(Chip_W, Chip_L, Chip_H))
  Box1.unite(Chip_sub)
  Chip [Sapphire] = box(corner=((Q_chip_loc_x) - ((Chip_W) / (2)), (Q_chip_loc_y) - ((Chip_L) / (2)), (Q_chip_loc_z) - ((Chip_H) / (2))), size=(Chip_W, Chip_L, Chip_H))
  Pad_1 = rectangle(corner=(pad_x, pad_y, pad_z), x_size=pad_w, y_size=pad_l)
  Pad_2 = rectangle(corner=(pad_x, pad_y_2, pad_z), x_size=pad_w, y_size=pad_l)
  jj = rectangle(corner=(junc_x, junc_y, pad_z), x_size=jj_w, y_size=pad_gap)
  jj_line = polyline((-25.4mm, 7.9675mm, 28.775mm) (-25.4mm, 8.0675mm, 28.775mm))
boundaries and excitations:
  Top_Imped: Impedance Faces=Box1.face(at (-10.2858, 7.9375, 0), at (-16.3182, 7.9375, 0), at (-22.3507, 7.9375, 0), at (-28.3832, 7.9375, 0), at (-34.4157, 7.9375, 0), at (-40.4482, 7.9375, 0)) Resistance=377 Reactance=0
  Bot_Imped: Impedance Faces=Box1.face(at (-13.302, 7.9375, 57.15), at (-19.3345, 7.9375, 57.15), at (-25.367, 7.9375, 57.15), at (-31.3995, 7.9375, 57.15), at (-37.432, 7.9375, 57.15)) Resistance=377 Reactance=0
  TPads: Perfect E Objects=[Pad_1, Pad_2]
  jj1_RLC: Lumped RLC Objects=jj CurrentLine{middle of jj.edge(y at corner) -> middle of jj.edge(y opposite corner)} RLC_Type=Parallel Inductance=Lj_1
mesh:
  jj: LengthBased Objects=jj MaxLength=20um
  pads: LengthBased Objects=[Pad_1, Pad_2] MaxLength=100um
  substrate: LengthBased Objects=Chip MaxLength=1mm
setups:
  Qubit_EM: HfssEigen MinimumFrequency=4GHz NumModes=2 MaxDeltaFreq=0.5 ConvergeOnRealFreq=true MaximumPasses=20 MinimumPasses=1 MinimumConvergedPasses=1 PercentRefinement=30 BasisOrder=-1
source amplitudes:
  #-10:1: 1 0deg
  #-10:2: 0 0deg
optimetrics:
  Lj_Sweep: Parametric Sim._Setups=[Qubit_EM]
    sweep Lj_1: LIN 11.00nH 11.40nH 0.20nH
field plots:
  Mesh1: MeshPlots over jj.face on Qubit_EM : LastAdaptive at Phase=0deg
  Mesh2: MeshPlots over Pad_2.face on Qubit_EM : LastAdaptive at Phase=0deg
