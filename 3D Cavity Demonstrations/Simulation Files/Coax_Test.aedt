# Ansys Electronics Desktop project, version 2021.1
materials:
  vacuum: permittivity=1
  sapphire: permittivity=10
  copper: permeability=0.999991 conductivity=58000000

design Coax (HFSS, Eigenmode, model units mm)
variables:
  Stock_H = 2in
  Cyl_R = 0.5in
geometry:
  Solid1 = imported_body(C:\_Lib\python\Automated-RF-Design\3D Cavity Demonstrations\00000_coax_test.stp)
  Cylinder1 [vacuum] = cylinder(axis=Z, base_centre=(0, 0, ((Stock_H) / (2)) - ((Stock_H) / (2))), radius=Cyl_R, height=Stock_H)
  Cylinder1.subtract(Solid1)
boundaries and excitations:
  Imped: Impedance Faces=Cylinder1.face(3 of 3) Resistance=377 Reactance=0
setups:
  Test_EM: HfssEigen MinimumFrequency=2GHz NumModes=2 MaxDeltaFreq=0.1 ConvergeOnRealFreq=true MaximumPasses=10 MinimumPasses=1 MinimumConvergedPasses=1 PercentRefinement=30 BasisOrder=-1
source amplitudes:
  #-10:1: 0 0
  #-10:2: 1 0
field calculator expressions:
  E_energy_S_to_V = Fundamental_Quantity(0) | Mag | 2 | Pow | EnterSurface(AllObjects) | SurfaceValue | Integrate | Fundamental_Quantity(0) | Mag | 2 | Pow | EnterVolume(AllObjects) | VolumeValue | Integrate | /
  H_energy_S_to_V = <Hx,Hy,Hz> | Mag | 2 | Pow | EnterSurface(AllObjects) | SurfaceValue | Integrate | <Hx,Hy,Hz> | Mag | 2 | Pow | EnterVolume(AllObjects) | VolumeValue | Integrate | /

design Coax_EPR (HFSS, Eigenmode, model units mm)
variables:
  Stock_H = 2in
  Cyl_R = 0.5in
  cav_R = 0.3in
  Q_hole_len = 0.4in
  Q_hole_dia = 0.125in
  Q_hole_loc_x = 0.2in
  Q_hole_loc_y = 0
  Q_hole_loc_z = 0.4in
  Q_chip_x_offset = 0.25in
  Chip_W = 2mm
  Chip_L = 15mm
  Chip_H = 0.4mm
  Q_chip_loc_x = 13.85mm
  Q_chip_loc_y = 0
  Q_chip_loc_z = 10.16mm
  pad_x_offset = 0.5mm
  pad_l = 0.8mm
  pad_w = 350um
  pad_gap = 100um
  pad_x = 6.85mm
  pad_y = -0.175mm
  pad_z = 10.36mm
  jj_w = 50um
  pad_x_2 = 7.75mm
  junc_x = 7.65mm
  junc_y = -0.025mm
  Lj_1 = 8.2nH
geometry:
  Solid1 = imported_body(C:\_Lib\python\Automated-RF-Design\3D Cavity Demonstrations\00000_coax_test.stp)
  Cylinder1 [vacuum] = cylinder(axis=Z, base_centre=(0, 0, ((Stock_H) / (2)) - ((Stock_H) / (2))), radius=Cyl_R, height=Stock_H)
  Cylinder1.subtract(Solid1)
  Q_Hole = cylinder(axis=X, base_centre=(Q_hole_loc_x, Q_hole_loc_y, Q_hole_loc_z), radius=(Q_hole_dia) / (2), height=Q_hole_len)
  Cylinder1.unite(Q_Hole)
  Chip_sub = box(corner=((Q_chip_loc_x) - ((Chip_L) / (2)), (Q_chip_loc_y) - ((Chip_W) / (2)), (Q_chip_loc_z) - ((Chip_H) / (2))), size=(Chip_L, Chip_W, Chip_H))
  Cylinder1.unite(Chip_sub)
  Chip [Sapphire] = box(corner=((Q_chip_loc_x) - ((Chip_L) / (2)), (Q_chip_loc_y) - ((Chip_W) / (2)), (Q_chip_loc_z) - ((Chip_H) / (2))), size=(Chip_L, Chip_W, Chip_H))
  Pad_1 = rectangle(corner=(pad_x, pad_y, pad_z), x_size=pad_l, y_size=pad_w)
  Pad_2 = rectangle(corner=(pad_x_2, pad_y, pad_z), x_size=pad_l, y_size=pad_w)
  jj = rectangle(corner=(junc_x, junc_y, pad_z), x_size=pad_gap, y_size=jj_w)
  jj_line = polyline((7.7mm, -0.025mm, 10.36mm) (7.7mm, 0.025mm, 10.36mm))
boundaries and excitations:
  Imped: Impedance Faces=Cylinder1.face(3 of 3) Resistance=377 Reactance=0
  TPads: Perfect E Objects=[Pad_1, Pad_2]
  jj1_RLC: Lumped RLC Objects=jj CurrentLine{middle of jj.edge(y at corner) -> middle of jj.edge(y opposite corner)} RLC_Type=Parallel Inductance=Lj_1
mesh:
  jj: LengthBased Objects=jj MaxLength=0.1mm
  pads: LengthBased Objects=[Pad_1, Pad_2] MaxLength=0.1mm
  substrate: LengthBased Objects=Chip MaxLength=0.1mm
setups:
  Qubit_EM: HfssEigen MinimumFrequency=0.5GHz NumModes=3 MaxDeltaFreq=0.5 ConvergeOnRealFreq=true MaximumPasses=20 MinimumPasses=1 MinimumConvergedPasses=1 PercentRefinement=30 BasisOrder=-1
source amplitudes:
  #-10:1, #-10:2: 0 0
  #-10:3: 1 0
optimetrics:
  Lj_Sweep: Parametric Sim._Setups=[Qubit_EM]
    sweep Lj_1: LIN 7.80nH 8.20nH 0.20nH
reports:
  Freq. vs. pass: re(Mode(1)), re(Mode(2)), re(Mode(3)) vs Pass on Qubit_EM : AdaptivePass

design Coax_Q3D (Q3D Extractor, model units mm)
options: SParamCalcMethod=EqTransLine Calculate_Lossy_Dielectrics
variables:
  Stock_H = 2in
  Cyl_R = 0.5in
  cav_R = 0.3in
  Q_hole_len = 0.4in
  Q_hole_dia = 0.125in
  Q_hole_loc_x = 0.2in
  Q_hole_loc_y = 0
  Q_hole_loc_z = 0.4in
  Q_chip_x_offset = 0.15in
  Chip_W = 2mm
  Chip_L = 10mm
  Chip_H = 0.4mm
  Q_chip_loc_x = (Q_chip_x_offset) + ((Chip_L) / (2))
  Q_chip_loc_y = 0
  Q_chip_loc_z = Q_hole_loc_z
  pad_x_offset = 0.5mm
  pad_l = 0.8mm
  pad_w = 350um
  pad_gap = 100um
  pad_x = ((Q_chip_loc_x) + (pad_x_offset)) - ((Chip_L) / (2))
  pad_y = (Q_chip_loc_y) - ((pad_w) / (2))
  pad_z = (Q_chip_loc_z) + ((Chip_H) / (2))
  jj_w = 50um
  pad_x_2 = ((pad_x) + (pad_l)) + (pad_gap)
  pad_t = 200nm
geometry:
  Solid1 = imported_body(C:\_Lib\python\Automated-RF-Design\3D Cavity Demonstrations\00000_coax_test.stp)
  Cylinder1 [vacuum] = cylinder(axis=Z, base_centre=(0, 0, ((Stock_H) / (2)) - ((Stock_H) / (2))), radius=Cyl_R, height=Stock_H)
  Cylinder1.subtract(Solid1)
  Q_Hole = cylinder(axis=X, base_centre=(Q_hole_loc_x, Q_hole_loc_y, Q_hole_loc_z), radius=(Q_hole_dia) / (2), height=Q_hole_len)
  Cylinder1.unite(Q_Hole)
  Chip_sub = box(corner=((Q_chip_loc_x) - ((Chip_L) / (2)), (Q_chip_loc_y) - ((Chip_W) / (2)), (Q_chip_loc_z) - ((Chip_H) / (2))), size=(Chip_L, Chip_W, Chip_H))
  Cylinder1.unite(Chip_sub)
  Chip [Sapphire] = box(corner=((Q_chip_loc_x) - ((Chip_L) / (2)), (Q_chip_loc_y) - ((Chip_W) / (2)), (Q_chip_loc_z) - ((Chip_H) / (2))), size=(Chip_L, Chip_W, Chip_H))
  Pad_1 [copper] = rectangle(corner=(pad_x, pad_y, pad_z), x_size=pad_l, y_size=pad_w)
  Pad_2 [copper] = rectangle(corner=(pad_x_2, pad_y, pad_z), x_size=pad_l, y_size=pad_w)
boundaries and excitations:
  Pad_1_thin_cond: ThinConductor Objects=Pad_1 Material=Copper Thickness=pad_t
  Pad_2_thin_cond: ThinConductor Objects=Pad_2 Material=Copper Thickness=pad_t
  Pad_1_Net: SignalNet Objects=Pad_1
  Pad_2_Net: SignalNet Objects=Pad_2
setups:
  Ec_Test: Matrix AdaptiveFreq=5GHz Cap{MaxPass=10 MinPass=1 MinConvPass=1 PerError=1 PerRefine=30 SolutionOrder=High Solver_Type=Iterative}
source amplitudes:
  Pad_1_Net: Cap 1V 0deg
  Pad_2_Net: Cap 0V 0deg
