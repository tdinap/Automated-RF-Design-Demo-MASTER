# Ansys Electronics Desktop project, version 2021.1
materials:
  vacuum: permittivity=1

design Pan_pipe_Test (HFSS, Eigenmode, model units mm)
variables:
  Stock_L = -2in
  Stock_W = 0.625in
  Stock_H = 2.25in
geometry:
  Solid1 = imported_body(C:\_Lib\python\Automated-RF-Design\3D Cavity Demonstrations\Inventor Files\\00001_single_mode_flute.stp)
  Box1 [vacuum] = box(corner=(0, 0, 0), size=(Stock_L, Stock_W, Stock_H))
  Box1.subtract(Solid1)
boundaries and excitations:
  Top_Imped: Impedance Faces=Box1.face(at (-10.2858, 7.9375, 0), at (-16.3182, 7.9375, 0), at (-22.3507, 7.9375, 0), at (-28.3832, 7.9375, 0), at (-34.4157, 7.9375, 0), at (-40.4482, 7.9375, 0)) Resistance=377 Reactance=0
  Bot_Imped: Impedance Faces=Box1.face(at (-13.302, 7.9375, 57.15), at (-19.3345, 7.9375, 57.15), at (-25.367, 7.9375, 57.15), at (-31.3995, 7.9375, 57.15), at (-37.432, 7.9375, 57.15)) Resistance=377 Reactance=0
setups:
  Test_EM: HfssEigen MinimumFrequency=2GHz NumModes=5 MaxDeltaFreq=0.1 ConvergeOnRealFreq=true MaximumPasses=10 MinimumPasses=1 MinimumConvergedPasses=1 PercentRefinement=30 BasisOrder=-1
source amplitudes:
  #-10:1: 1 0deg
  #-10:2..#-10:5: 0 0deg
field calculator expressions:
  E_energy_S_to_V = Fundamental_Quantity(0) | Mag | 2 | Pow | EnterSurface(AllObjects) | SurfaceValue | Integrate | Fundamental_Quantity(0) | Mag | 2 | Pow | EnterVolume(AllObjects) | VolumeValue | Integrate | /
  H_energy_S_to_V = <Hx,Hy,Hz> | Mag | 2 | Pow | EnterSurface(AllObjects) | SurfaceValue | Integrate | <Hx,Hy,Hz> | Mag | 2 | Pow | EnterVolume(AllObjects) | VolumeValue | Integrate | /
field plots:
  Mag_E1: E Field in Box1 on Test_EM : LastAdaptive at Phase=0deg
