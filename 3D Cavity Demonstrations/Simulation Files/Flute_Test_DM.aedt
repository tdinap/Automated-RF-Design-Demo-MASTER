# Ansys Electronics Desktop project, version 2021.1
materials:
  vacuum: permittivity=1
  sapphire: permittivity=10

design qubit_DM (HFSS, DrivenModal, model units mm)
variables:
  Stock_L = -2in
  Stock_W = 0.625in
  Stock_H = 2.25in
  Cav_width = 0.188in
  Q_hole_len = (((Stock_W) - (Cav_width)) / (2)) + ((Cav_width) / (2))
  Q_hole_dia = 0.125in
  Q_hole_loc_x = (Stock_L) / (2)
  Q_hole_loc_y = Stock_W
  Q_hole_loc_z = (Stock_H) / (2)
  Q_chip_y_offset = -0.05in
  Chip_W = 2.9mm
  Chip_L = 10mm
  Chip_H = 0.4mm
  Q_chip_loc_x = Q_hole_loc_x
  Q_chip_loc_y = (((Stock_W) / (2)) + ((Chip_L) / (2))) + (Q_chip_y_offset)
  Q_chip_loc_z = Q_hole_loc_z
  pad_y_offset = 0.5mm
  pad_l = 0.8mm
  pad_w = 350um
  pad_gap = 100um
  pad_x = (Q_chip_loc_x) - ((pad_w) / (2))
  pad_y = ((Q_chip_loc_y) + (pad_y_offset)) - ((Chip_L) / (2))
  pad_z = (Q_chip_loc_z) + ((Chip_H) / (2))
  jj_w = 50um
  pad_y_2 = ((pad_y) + (pad_l)) + (pad_gap)
  junc_y = (pad_y) + (pad_l)
  junc_x = (pad_x) + (((pad_w) - (jj_w)) / (2))
geometry:
  Solid1 = imported_body(C:\_Lib\python\Automated-RF-Design\3D Cavity Demonstrations\Inventor Files\\00001_single_mode_flute.stp)
  Box1 [Vacuum] = box(corner=(0, 0, 0), size=(Stock_L, Stock_W, Stock_H))
  Box1.subtract(Solid1)
  Q_Hole = cylinder(axis=Y, base_centre=(Q_hole_loc_x, Q_hole_loc_y, Q_hole_loc_z), radius=(Q_hole_dia) / (2), height=-(Q_hole_len))
  Box1.unite(Q_Hole)
  Chip_sub = box(corner=((Q_chip_loc_x) - ((Chip_W) / (2)), (Q_chip_loc_y) - ((Chip_L) / (2)), (Q_chip_loc_z) - ((Chip_H) / (2))), size=(Chip_W, Chip_L, Chip_H))
  Box1.unite(Chip_sub)
  Chip [Sapphire] = box(corner=((Q_chip_loc_x) - ((Chip_W) / (2)), (Q_chip_loc_y) - ((Chip_L) / (2)), (Q_chip_loc_z) - ((Chip_H) / (2))), size=(Chip_W, Chip_L, Chip_H))
  Pad_1 = rectangle(corner=(pad_x, pad_y, pad_z), x_size=pad_w, y_size=pad_l)
  Pad_2 = rectangle(corner=(pad_x, pad_y_2, pad_z), x_size=pad_w, y_size=pad_l)
  jj = rectangle(corner=(junc_x, junc_y, pad_z), x_size=jj_w, y_size=pad_gap)
boundaries and excitations:
  TPads: Perfect E Objects=[Pad_1, Pad_2]
  JJ_port_1: Lumped Port Objects=jj Modes{Mode1{IntLine{middle of jj.edge(y at corner) -> middle of jj.edge(y opposite corner)} CharImp=Zpi RenormImp=50ohm}} Impedance=50ohm
setups:
  QTune_DM: HfssDriven Frequency=1GHz MaxDeltaS=0.1 MaximumPasses=10 MinimumPasses=1 MinimumConvergedPasses=1 PercentRefinement=30 BasisOrder=-1 PortAccuracy=2
    sweep Sweep: 5GHz to 7GHz, 10000 points; Type=Fast
source amplitudes:
  JJ_port_1:1: 1W 0deg
